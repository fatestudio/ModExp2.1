[IBIS Ver] 3.2
[File Name] modexp.ibs
[File Rev] 1.6
[Date] August 12, 2013
[Source] Altera, Quartus II 64-Bit 12.1
[Notes]
| The models are designated as "Final" and have been
| correlated against physical device operation.
Unused IOs which have been assigned as tri-stated inputs or
as outputs driving any signal in Quartus II are represented by the NC.
[Disclaimer] Data is for modeling purposes only and is not guaranteed.
[Copyright] Copyright (C) 1991-2012 Altera Corporation
[Component] EP2C50F484C6_ModExp
[Manufacturer]  Altera Corporation
[Package]
| RLC values are for 484 FBGA package
|variable  typ  min  max
R_pkg  231.00m   125.00m   327.00m
L_pkg  4.00nH   2.50nH   5.32nH
C_pkg  0.73pF   0.53pF   0.92pF
[Pin]  signal_name   model_name   R_pin   L_pin   C_pin
A1   GND   GND
A2   VCCIO3   POWER
A9   nprime0_buf[4]   2c_ttl33_cin
A10   nprime0_buf[2]   2c_ttl33_cin
A11   e_buf[14]   2c_ttl33_cin
A13   t_buf[15]   2c_ttl33_cin
A14   e_buf[12]   2c_ttl33_cin
A16   e_buf[3]   2c_ttl33_cin
A21   VCCIO4   POWER
A22   GND   GND
AA1   VCCIO1   POWER
AA2   GND   GND
AA5   n_buf[13]   2c_ttl33_cin
AA8   m_buf[5]   2c_ttl33_cin
AA9   nprime0_buf[6]   2c_ttl33_cin
AA10   t_buf[11]   2c_ttl33_cin
AA11   m_buf[8]   2c_ttl33_cin
AA12   t_buf[12]   2c_ttl33_cin
AA13   t_buf[0]   2c_ttl33_cin
AA21   GND   GND
AA22   VCCIO6   POWER
AB1   GND   GND
AB2   VCCIO8   POWER
AB8   nprime0_buf[15]   2c_ttl33_cin
AB9   nprime0_buf[14]   2c_ttl33_cin
AB10   t_buf[2]   2c_ttl33_cin
AB11   t_buf[7]   2c_ttl33_cin
AB12   t_buf[4]   2c_ttl33_cin
AB13   m_buf[7]   2c_ttl33_cin
AB21   VCCIO7   POWER
AB22   GND   GND
B1   VCCIO2   POWER
B2   GND   GND
B7   e_buf[6]   2c_ttl33_cin
B9   nprime0_buf[3]   2c_ttl33_cin
B10   m_buf[2]   2c_ttl33_cin
B13   nprime0_buf[8]   2c_ttl33_cin
B14   nprime0_buf[10]   2c_ttl33_cin
B15   r_buf[1]   2c_ttl33_cin
B16   e_buf[1]   2c_ttl33_cin
B21   GND   GND
B22   VCCIO5   POWER
C5   GND   GND
C6   VCCIO3   POWER
C8   GND   GND
C9   e_buf[5]   2c_ttl33_cin
C10   nprime0_buf[7]   2c_ttl33_cin
C11   VCCIO3   POWER
C12   VCCIO4   POWER
C13   e_buf[13]   2c_ttl33_cin
C15   GND   GND
D4   e_buf[7]   2c_ttl33_rin
D8   e_buf[8]   2c_ttl33_cin
D9   e_buf[11]   2c_ttl33_cin
D10   GND   GND
D11   nprime0_buf[1]   2c_ttl33_cin
D13   GND   GND
D14   e_buf[0]   2c_ttl33_cin
D15   r_buf[2]   2c_ttl33_cin
D17   VCCIO4   POWER
D18   GND   GND
D19   r_buf[6]   2c_ttl33_rin
E1   r_buf[3]   2c_ttl33_rin
E2   r_buf[9]   2c_ttl33_rin
E5   VCCD_PLL3   POWER
E6   VCCA_PLL3   POWER
E7   r_buf[7]   2c_ttl33_cin
E8   m_buf[0]   2c_ttl33_cin
E9   e_buf[10]   2c_ttl33_cin
E10   VCCIO3   POWER
E11   e_buf[2]   2c_ttl33_cin
E13   VCCIO4   POWER
E14   exp_state[2]   2c_ttl33_cio_d24
E15   state[3]   2c_ttl33_cio_d24
E16   NC   NC
E17   GND_PLL2   GND
F2   m_buf[3]   2c_ttl33_rin
F5   GND_PLL3   GND
F6   GND_PLL3   GND
F7   NC   NC
F9   e_buf[9]   2c_ttl33_cin
F10   e_buf[15]   2c_ttl33_cin
F11   nprime0_buf[0]   2c_ttl33_cin
F12   r_buf[5]   2c_ttl33_cin
F13   getResult   2c_ttl33_cin
F14   e_buf[4]   2c_ttl33_cin
F16   VCCA_PLL2   POWER
F17   VCCD_PLL2   POWER
F18   GND_PLL2   GND
F19   GND   GND
F21   r_buf[11]   2c_ttl33_rin
G1   r_buf[15]   2c_ttl33_rin
G2   t_buf[6]   2c_ttl33_rin
G4   GND   GND
G7   VCCINT   POWER
G8   VCCINT   POWER
G9   VCCIO3   POWER
G10   GND   GND
G11   GND   GND
G12   VCCINT   POWER
G13   GND   GND
G14   VCCIO4   POWER
G15   GND   GND
G16   VCCINT   POWER
G17   r_buf[14]   2c_ttl33_rin
G19   VCCIO5   POWER
H1   m_buf[12]   2c_ttl33_rin
H2   m_buf[14]   2c_ttl33_rin
H3   m_buf[1]   2c_ttl33_rin
H6   r_buf[8]   2c_ttl33_rin
H7   VCCINT   POWER
H8   VCCINT   POWER
H9   GND   GND
H10   GND   GND
H11   GND   GND
H12   VCCINT   POWER
H13   VCCINT   POWER
H14   GND   GND
H15   GND   GND
H16   VCCINT   POWER
H20   GND   GND
J1   m_buf[6]   2c_ttl33_rin
J2   m_buf[13]   2c_ttl33_rin
J3   t_buf[10]   2c_ttl33_rin
J4   t_buf[8]   2c_ttl33_rin
J5   m_buf[11]   2c_ttl33_rin
J6   t_buf[9]   2c_ttl33_rin
J7   VCCIO2   POWER
J8   GND   GND
J9   GND   GND
J10   VCCINT   POWER
J11   VCCINT   POWER
J12   VCCINT   POWER
J13   VCCINT   POWER
J14   GND   GND
J15   GND   GND
J16   VCCIO5   POWER
J17   r_buf[13]   2c_ttl33_rin
J21   nprime0_buf[13]   2c_ttl33_rin
K1   nCE   2c_ttl33_cin
K2   TCK   2c_ttl33_cin
K3   GND   GND
K4   DATA0   2c_ttl33_cin
K5   TDI   2c_ttl33_cin
K6   TMS   2c_ttl33_cin
K7   GND   GND
K8   VCCINT   POWER
K9   VCCINT   POWER
K10   GND   GND
K11   GND   GND
K12   GND   GND
K13   GND   GND
K14   VCCINT   POWER
K15   GND   GND
K16   GND   GND
K17   r_buf[10]   2c_ttl33_rin
K18   state[2]   2c_ttl33_rio_d24
K19   GND   GND
K22   state[1]   2c_ttl33_rio_d24
L3   VCCIO2   POWER
L4   nCONFIG   2c_ttl33_cin
L5   TDO   2c_ttl33_tdo
L6   DCLK   2c_ttl33_dclk
L7   VCCINT   POWER
L8   VCCINT   POWER
L9   VCCINT   POWER
L10   GND   GND
L11   GND   GND
L12   GND   GND
L13   GND   GND
L14   VCCINT   POWER
L15   GND   GND
L16   VCCINT   POWER
L19   r_buf[12]   2c_ttl33_rin
L20   VCCIO5   POWER
L21   startCompute   2c_ttl33_rin
L22   startInput   2c_ttl33_rin
M1   clk   2c_ttl33_rin
M2   reset   2c_ttl33_rin
M3   VCCIO1   POWER
M4   GND   GND
M5   t_buf[3]   2c_ttl33_rin
M6   res_out[8]   2c_ttl33_rio_d24
M7   GND   GND
M8   GND   GND
M9   VCCINT   POWER
M10   GND   GND
M11   GND   GND
M12   GND   GND
M13   GND   GND
M14   VCCINT   POWER
M15   VCCINT   POWER
M16   GND   GND
M17   MSEL0   2c_ttl33_cin
M19   t_buf[5]   2c_ttl33_rin
M20   VCCIO6   POWER
M21   m_buf[9]   2c_ttl33_rin
M22   m_buf[10]   2c_ttl33_rin
N1   res_out[7]   2c_ttl33_rio_d24
N2   nprime0_buf[5]   2c_ttl33_rin
N4   res_out[10]   2c_ttl33_rio_d24
N5   res_out[3]   2c_ttl33_rio_d24
N6   res_out[12]   2c_ttl33_rio_d24
N7   GND   GND
N8   GND   GND
N9   VCCINT   POWER
N10   GND   GND
N11   GND   GND
N12   GND   GND
N13   GND   GND
N14   VCCINT   POWER
N15   VCCINT   POWER
N16   GND   GND
N17   MSEL1   2c_ttl33_cin
N18   CONF_DONE   2c_ttl33_cfdone
N19   GND   GND
N20   nSTATUS   2c_ttl33_nstatus
P1   res_out[9]   2c_ttl33_rio_d24
P2   t_buf[14]   2c_ttl33_rin
P3   nprime0_buf[11]   2c_ttl33_rin
P4   r_buf[0]   2c_ttl33_rin
P5   r_buf[4]   2c_ttl33_rin
P6   res_out[15]   2c_ttl33_rio_d24
P7   VCCIO1   POWER
P8   GND   GND
P9   GND   GND
P10   VCCINT   POWER
P11   VCCINT   POWER
P12   VCCINT   POWER
P13   VCCINT   POWER
P14   VCCINT   POWER
P15   GND   GND
P16   VCCIO6   POWER
P22   state[0]   2c_ttl33_rio_d24
R1   res_out[0]   2c_ttl33_rio_d24
R3   GND   GND
R4   n_buf[9]   2c_ttl33_rin
R5   n_buf[14]   2c_ttl33_rin
R6   n_buf[12]   2c_ttl33_rin
R7   VCCINT   POWER
R8   VCCINT   POWER
R9   GND   GND
R10   VCCINT   POWER
R11   GND   GND
R12   VCCINT   POWER
R13   GND   GND
R14   GND   GND
R15   VCCINT   POWER
R16   VCCINT   POWER
T2   nprime0_buf[9]   2c_ttl33_rin
T3   n_buf[15]   2c_ttl33_rin
T4   VCCIO1   POWER
T5   res_out[13]   2c_ttl33_rio_d24
T6   res_out[14]   2c_ttl33_rio_d24
T7   VCCINT   POWER
T8   VCCINT   POWER
T9   VCCIO8   POWER
T10   GND   GND
T11   GND   GND
T12   VCCINT   POWER
T13   GND   GND
T14   VCCIO7   POWER
T15   VCCINT   POWER
T16   GND   GND
T17   GND_PLL4   GND
T19   VCCIO6   POWER
T20   GND   GND
U1   res_out[5]   2c_ttl33_rio_d24
U2   res_out[6]   2c_ttl33_rio_d24
U3   n_buf[10]   2c_ttl33_rin
U4   n_buf[4]   2c_ttl33_rin
U5   GND_PLL1   GND
U6   VCCD_PLL1   POWER
U7   VCCA_PLL1   POWER
U16   VCCA_PLL4   POWER
U17   VCCD_PLL4   POWER
U18   exp_state[1]   2c_ttl33_rio_d24
V1   n_buf[1]   2c_ttl33_rin
V2   res_out[4]   2c_ttl33_rio_d24
V3   GND   GND
V4   n_buf[6]   2c_ttl33_rin
V5   GND_PLL1   GND
V6   GND   GND
V7   NC   NC
V8   m_buf[4]   2c_ttl33_cin
V10   VCCIO8   POWER
V11   t_buf[13]   2c_ttl33_cin
V13   VCCIO7   POWER
V16   NC   NC
V17   GND   GND
V18   GND_PLL4   GND
V22   exp_state[0]   2c_ttl33_rio_d24
W1   res_out[2]   2c_ttl33_rio_d24
W2   res_out[1]   2c_ttl33_rio_d24
W3   n_buf[11]   2c_ttl33_rin
W4   n_buf[8]   2c_ttl33_rin
W5   n_buf[0]   2c_ttl33_rin
W6   VCCIO8   POWER
W7   m_buf[15]   2c_ttl33_cin
W10   GND   GND
W11   t_buf[1]   2c_ttl33_cin
W13   GND   GND
W17   VCCIO7   POWER
W18   exp_state[3]   2c_ttl33_rio_d24
W19   GND   GND
W20   ~LVDS142p/nCEO~   2c_ttl33_nceo
Y1   res_out[11]   2c_ttl33_rio_d24
Y2   n_buf[2]   2c_ttl33_rin
Y3   n_buf[5]   2c_ttl33_rin
Y4   n_buf[7]   2c_ttl33_rin
Y5   n_buf[3]   2c_ttl33_cin
Y8   GND   GND
Y10   nprime0_buf[12]   2c_ttl33_cin
Y11   VCCIO8   POWER
Y12   VCCIO7   POWER
Y15   GND   GND
Y17   exp_state[4]   2c_ttl33_cio_d24
| Models and submodels in the file (9): 2c_ttl33_cin (Input), 2c_ttl33_rin (Input), 2c_ttl33_cio_d24 (I/O), 2c_ttl33_rio_d24 (I/O), 2c_ttl33_tdo (Output), 2c_ttl33_dclk (I/O), 2c_ttl33_cfdone (I/O_open_drain), 2c_ttl33_nstatus (I/O_open_drain), 2c_ttl33_nceo (Output)
